# Ansys Electronics Desktop project, version 2018.2
materials:
  steel_1010: permittivity=1 permeability{BType=normal HUnit=A_per_meter BUnit=tesla curve (0, 0) (238.7, 0.2003) (318.3, 0.3204) (358.1, 0.40045) (437.7, 0.50055) (477.5, 0.5606) (636.6, 0.7908) (795.8, 0.931) (1114.1, 1.1014) (1273.2, 1.2016) (1591.5, 1.302) (2228.2, 1.4028) (3183.1, 1.524) (4774.6, 1.626) (6366.2, 1.698) (7957.7, 1.73) (15915.5, 1.87) (31831, 1.99) (47746.5, 2.04) (63662, 2.07) (79577.5, 2.095) (159155, 2.2) (318310, 2.4)} conductivity=2000000 lande_g_factor=2 mass_density=7872
  steel_1008: permeability{BType=normal HUnit=A_per_meter BUnit=tesla curve (0, 0) (159.2, 0.2402) (318.3, 0.8654) (477.5, 1.1106) (636.6, 1.2458) (795.8, 1.331) (1591.5, 1.5) (3183.1, 1.6) (4774.6, 1.683) (6366.2, 1.741) (7957.7, 1.78) (15915.5, 1.905) (31831, 2.025) (47746.5, 2.085) (63662, 2.13) (79577.5, 2.165) (159155, 2.28) (318310, 2.485) (397887, 2.5851)} conductivity=2000000 mass_density=7872
  NdFe30: permittivity=1 permeability=1.044573 conductivity=625000 magnetic_coercivity{Magnitude=-838000A_per_meter DirComp1=1 DirComp2=0 DirComp3=0} lande_g_factor=2 mass_density=7550
  assump: permeability=1e+21 conductivity=1e+21
  NdFe35: permittivity=1 permeability=1.0997785 conductivity=625000 magnetic_coercivity{Magnitude=-890000A_per_meter DirComp1=1 DirComp2=0 DirComp3=0} lande_g_factor=2 mass_density=7400
  SmCo24: permittivity=1 permeability=1.0631382 conductivity=1111111 magnetic_coercivity{Magnitude=-756000A_per_meter DirComp1=1 DirComp2=0 DirComp3=0} lande_g_factor=2 mass_density=8300
  Arnold_Magnetics_N42M_100C: permeability{BType=normal HUnit=A_per_meter BUnit=tesla curve (-538000, -0.6999) (-537000, -0.1695) (-533000, 0.2386) (-525000, 0.3936) (-519000, 0.4376) (-513000, 0.4645) (-506000, 0.4843) (-500000, 0.5004) (-494000, 0.5143) (-487000, 0.5268) (-481000, 0.5384) (-475000, 0.5494) (-468000, 0.5598) (-462000, 0.5699) (-456000, 0.5797) (-449000, 0.5893) (-443000, 0.5987) (-437000, 0.608) (-430000, 0.6171) (-424000, 0.6261) (-418000, 0.6351) (-411000, 0.644) (-405000, 0.6528) (-399000, 0.6616) (-392000, 0.6703) (-386000, 0.679) (-380000, 0.6876) (-374000, 0.6963) (-367000, 0.7049) (-361000, 0.7134) (-355000, 0.722) (-348000, 0.7305) (-342000, 0.739) (-336000, 0.7475) (-329000, 0.7559) (-323000, 0.7644) (-317000, 0.7728) (-310000, 0.7813) (-304000, 0.7897) (-298000, 0.7981) (-291000, 0.8065) (-285000, 0.8149) (-279000, 0.8233) (-272000, 0.8317) (-266000, 0.84) (-260000, 0.8484) (-253000, 0.8568) (-247000, 0.8651) (-241000, 0.8735) (-234000, 0.8818) (-228000, 0.8902) (-222000, 0.8985) (-215000, 0.9068) (-209000, 0.9152) (-203000, 0.9235) (-196000, 0.9318) (-190000, 0.9401) (-184000, 0.9484) (-177000, 0.9568) (-171000, 0.9651) (-165000, 0.9734) (-158000, 0.9817) (-152000, 0.99) (-146000, 0.9983) (-139000, 1.0066) (-133000, 1.0149) (-127000, 1.0232) (-120000, 1.0315) (-114000, 1.0398) (-108000, 1.048) (-101000, 1.0563) (-95000, 1.0646) (-89000, 1.0729) (-82000, 1.0812) (-76000, 1.0895) (-70000, 1.0977) (-63000, 1.106) (-57000, 1.1143) (-51000, 1.1226) (-44000, 1.1309) (-38000, 1.1391) (-32000, 1.1474) (-25000, 1.1557) (-19000, 1.164) (-13000, 1.1722) (-6000, 1.1805) (0, 1.1888)} conductivity=555555.5556 magnetic_coercivity{Magnitude=-1005300A_per_meter DirComp1=1 DirComp2=0 DirComp3=0} mass_density=7500
  Arnold_Magnetics_N42SH_-40C: permeability{BType=normal HUnit=A_per_meter BUnit=tesla curve (-2427000, -3.1572) (-2415000, -2.2036) (-2403000, -1.9999) (-2370000, -1.8106) (-2342000, -1.7313) (-2313000, -1.672) (-2285000, -1.6212) (-2256000, -1.5748) (-2228000, -1.5309) (-2199000, -1.4887) (-2170000, -1.4476) (-2142000, -1.4073) (-2113000, -1.3675) (-2085000, -1.3282) (-2056000, -1.2892) (-2028000, -1.2504) (-1999000, -1.2119) (-1971000, -1.1736) (-1942000, -1.1353) (-1913000, -1.0972) (-1885000, -1.0592) (-1856000, -1.0213) (-1828000, -0.9835) (-1799000, -0.9457) (-1771000, -0.908) (-1742000, -0.8703) (-1713000, -0.8327) (-1685000, -0.7951) (-1656000, -0.7575) (-1628000, -0.72) (-1599000, -0.6825) (-1571000, -0.645) (-1542000, -0.6075) (-1514000, -0.5701) (-1485000, -0.5326) (-1456000, -0.4952) (-1428000, -0.4578) (-1399000, -0.4205) (-1371000, -0.3831) (-1342000, -0.3457) (-1314000, -0.3084) (-1285000, -0.2711) (-1257000, -0.2337) (-1228000, -0.1964) (-1199000, -0.1591) (-1171000, -0.1218) (-1142000, -0.0845) (-1114000, -0.0472) (-1085000, -0.01) (-1057000, 0.0273) (-1028000, 0.0646) (-1000000, 0.1018) (-971000, 0.1391) (-942000, 0.1764) (-914000, 0.2136) (-885000, 0.2509) (-857000, 0.2881) (-828000, 0.3253) (-800000, 0.3626) (-771000, 0.3998) (-743000, 0.437) (-714000, 0.4743) (-685000, 0.5115) (-657000, 0.5487) (-628000, 0.5859) (-600000, 0.6232) (-571000, 0.6604) (-543000, 0.6976) (-514000, 0.7348) (-485000, 0.772) (-457000, 0.8092) (-428000, 0.8464) (-400000, 0.8836) (-371000, 0.9208) (-343000, 0.958) (-314000, 0.9952) (-286000, 1.0324) (-257000, 1.0696) (-228000, 1.1068) (-200000, 1.144) (-171000, 1.1812) (-143000, 1.2184) (-114000, 1.2556) (-86000, 1.2928) (-57000, 1.3299) (-29000, 1.3671) (0, 1.4043)} conductivity=555555.5556 magnetic_coercivity{Magnitude=-1077560.4A_per_meter DirComp1=1 DirComp2=0 DirComp3=0} mass_density=7500
  Arnold_Magnetics_N42_-40C: permeability{BType=normal HUnit=A_per_meter BUnit=tesla curve (-1586000, -2.0627) (-1578000, -1.111) (-1570000, -0.912) (-1549000, -0.737) (-1530000, -0.6704) (-1511000, -0.6239) (-1493000, -0.5859) (-1474000, -0.5523) (-1455000, -0.5213) (-1437000, -0.492) (-1418000, -0.4637) (-1399000, -0.4363) (-1381000, -0.4094) (-1362000, -0.3829) (-1343000, -0.3568) (-1325000, -0.3309) (-1306000, -0.3053) (-1287000, -0.2798) (-1269000, -0.2544) (-1250000, -0.2292) (-1231000, -0.2041) (-1213000, -0.179) (-1194000, -0.1541) (-1175000, -0.1291) (-1157000, -0.1043) (-1138000, -0.0795) (-1119000, -0.0547) (-1101000, -0.03) (-1082000, -0.0053) (-1063000, 0.0193) (-1045000, 0.044) (-1026000, 0.0686) (-1008000, 0.0932) (-989000, 0.1177) (-970000, 0.1423) (-952000, 0.1668) (-933000, 0.1913) (-914000, 0.2158) (-896000, 0.2403) (-877000, 0.2648) (-858000, 0.2893) (-840000, 0.3137) (-821000, 0.3382) (-802000, 0.3626) (-784000, 0.387) (-765000, 0.4115) (-746000, 0.4359) (-728000, 0.4603) (-709000, 0.4847) (-690000, 0.5091) (-672000, 0.5335) (-653000, 0.5579) (-634000, 0.5823) (-616000, 0.6066) (-597000, 0.631) (-578000, 0.6554) (-560000, 0.6798) (-541000, 0.7041) (-522000, 0.7285) (-504000, 0.7528) (-485000, 0.7772) (-466000, 0.8015) (-448000, 0.8259) (-429000, 0.8502) (-410000, 0.8746) (-392000, 0.8989) (-373000, 0.9233) (-354000, 0.9476) (-336000, 0.9719) (-317000, 0.9963) (-299000, 1.0206) (-280000, 1.0449) (-261000, 1.0693) (-243000, 1.0936) (-224000, 1.1179) (-205000, 1.1422) (-187000, 1.1665) (-168000, 1.1909) (-149000, 1.2152) (-131000, 1.2395) (-112000, 1.2638) (-93000, 1.2881) (-75000, 1.3124) (-56000, 1.3368) (-37000, 1.3611) (-19000, 1.3854) (0, 1.4097)} conductivity=555555.5556 magnetic_coercivity{Magnitude=-1077902.1A_per_meter DirComp1=1 DirComp2=0 DirComp3=0} mass_density=7500
  Arnold_Magnetics_N42_20C: permeability{BType=normal HUnit=A_per_meter BUnit=tesla curve (-1003000, -1.3041) (-998000, -0.4195) (-993000, -0.237) (-979000, -0.0821) (-967000, -0.0272) (-956000, 0.0089) (-944000, 0.037) (-932000, 0.061) (-920000, 0.0826) (-908000, 0.1027) (-897000, 0.1218) (-885000, 0.1401) (-873000, 0.1579) (-861000, 0.1753) (-849000, 0.1924) (-838000, 0.2092) (-826000, 0.2258) (-814000, 0.2423) (-802000, 0.2587) (-790000, 0.2749) (-779000, 0.2911) (-767000, 0.3071) (-755000, 0.3231) (-743000, 0.3391) (-731000, 0.3549) (-720000, 0.3708) (-708000, 0.3866) (-696000, 0.4024) (-684000, 0.4181) (-672000, 0.4338) (-661000, 0.4495) (-649000, 0.4651) (-637000, 0.4808) (-625000, 0.4964) (-613000, 0.512) (-602000, 0.5276) (-590000, 0.5432) (-578000, 0.5587) (-566000, 0.5743) (-554000, 0.5898) (-543000, 0.6054) (-531000, 0.6209) (-519000, 0.6364) (-507000, 0.6519) (-495000, 0.6674) (-484000, 0.6829) (-472000, 0.6984) (-460000, 0.7138) (-448000, 0.7293) (-436000, 0.7448) (-425000, 0.7602) (-413000, 0.7757) (-401000, 0.7912) (-389000, 0.8066) (-377000, 0.822) (-366000, 0.8375) (-354000, 0.8529) (-342000, 0.8684) (-330000, 0.8838) (-319000, 0.8992) (-307000, 0.9146) (-295000, 0.9301) (-283000, 0.9455) (-271000, 0.9609) (-260000, 0.9763) (-248000, 0.9917) (-236000, 1.0071) (-224000, 1.0225) (-212000, 1.0379) (-201000, 1.0534) (-189000, 1.0688) (-177000, 1.0842) (-165000, 1.0996) (-153000, 1.115) (-142000, 1.1303) (-130000, 1.1457) (-118000, 1.1611) (-106000, 1.1765) (-94000, 1.1919) (-83000, 1.2073) (-71000, 1.2227) (-59000, 1.2381) (-47000, 1.2535) (-35000, 1.2689) (-24000, 1.2842) (-12000, 1.2996) (0, 1.315)} conductivity=555555.5556 magnetic_coercivity{Magnitude=-958439.45A_per_meter DirComp1=1 DirComp2=0 DirComp3=0} mass_density=7500
  Arnold_Magnetics_N35H_20C: permeability{BType=normal HUnit=A_per_meter BUnit=tesla curve (-1420000, -1.8475) (-1413000, -1.0303) (-1406000, -0.8591) (-1387000, -0.7078) (-1370000, -0.6497) (-1354000, -0.6089) (-1337000, -0.5754) (-1320000, -0.5457) (-1303000, -0.5182) (-1287000, -0.4921) (-1270000, -0.4669) (-1253000, -0.4424) (-1237000, -0.4184) (-1220000, -0.3948) (-1203000, -0.3715) (-1187000, -0.3484) (-1170000, -0.3254) (-1153000, -0.3026) (-1136000, -0.28) (-1120000, -0.2574) (-1103000, -0.2349) (-1086000, -0.2125) (-1070000, -0.1902) (-1053000, -0.1679) (-1036000, -0.1457) (-1019000, -0.1235) (-1003000, -0.1013) (-986000, -0.0792) (-969000, -0.0571) (-953000, -0.035) (-936000, -0.013) (-919000, 0.009) (-902000, 0.031) (-886000, 0.053) (-869000, 0.075) (-852000, 0.097) (-836000, 0.1189) (-819000, 0.1409) (-802000, 0.1628) (-785000, 0.1847) (-769000, 0.2066) (-752000, 0.2285) (-735000, 0.2504) (-719000, 0.2723) (-702000, 0.2942) (-685000, 0.316) (-668000, 0.3379) (-652000, 0.3598) (-635000, 0.3816) (-618000, 0.4035) (-602000, 0.4253) (-585000, 0.4471) (-568000, 0.469) (-551000, 0.4908) (-535000, 0.5126) (-518000, 0.5345) (-501000, 0.5563) (-485000, 0.5781) (-468000, 0.5999) (-451000, 0.6217) (-434000, 0.6435) (-418000, 0.6654) (-401000, 0.6872) (-384000, 0.709) (-368000, 0.7308) (-351000, 0.7526) (-334000, 0.7744) (-318000, 0.7962) (-301000, 0.818) (-284000, 0.8397) (-267000, 0.8615) (-251000, 0.8833) (-234000, 0.9051) (-217000, 0.9269) (-201000, 0.9487) (-184000, 0.9705) (-167000, 0.9922) (-150000, 1.014) (-134000, 1.0358) (-117000, 1.0576) (-100000, 1.0794) (-84000, 1.1011) (-67000, 1.1229) (-50000, 1.1447) (-33000, 1.1665) (-17000, 1.1882) (0, 1.21)} conductivity=555555.5556 magnetic_coercivity{Magnitude=-913700A_per_meter DirComp1=1 DirComp2=0 DirComp3=0} mass_density=7500
  vacuum: permittivity=1
  assump_2DSF0.950: permeability=9.5e+20
  Arnold_Magnetics_N35H_20C_2DSF1.000_N: CoordinateSystemType=Cylindrical permeability=1.03506 conductivity=555556 magnetic_coercivity{Magnitude=-928114A_per_meter DirComp1=1 DirComp2=0 DirComp3=0} mass_density=7500
  Arnold_Magnetics_N35H_20C_2DSF1.000_S: CoordinateSystemType=Cylindrical permeability=1.03506 conductivity=555556 magnetic_coercivity{Magnitude=-928114A_per_meter DirComp1=-1 DirComp2=0 DirComp3=0} mass_density=7500
  copper: permeability=0.999991 conductivity=58000000 mass_density=8933
  ChinaSteel_50CS400: permeability{BType=normal HUnit=A_per_meter BUnit=tesla curve (0, 0) (20, 0.042) (20.8512, 0.0447) (21.7386, 0.0476) (22.6638, 0.0506) (23.6283, 0.0539) (24.6339, 0.0573) (25.6824, 0.061) (26.7754, 0.065) (27.9149, 0.0694) (29.103, 0.0742) (30.3416, 0.0795) (31.6329, 0.0854) (32.9792, 0.0919) (34.3827, 0.0993) (35.846, 0.1075) (37.3716, 0.1169) (38.9621, 0.1275) (40.6204, 0.1397) (42.3491, 0.1535) (44.1515, 0.1692) (46.0305, 0.1871) (47.9896, 0.2074) (50.032, 0.2304) (52.1613, 0.2563) (54.3813, 0.285) (56.6957, 0.3165) (59.1086, 0.3503) (61.6243, 0.3862) (64.2469, 0.424) (66.9813, 0.464) (69.8319, 0.5065) (72.8039, 0.5515) (75.9024, 0.5983) (79.1328, 0.6457) (82.5006, 0.6922) (86.0118, 0.7379) (89.6724, 0.7839) (93.4888, 0.831) (97.4677, 0.8762) (101.616, 0.9147) (105.941, 0.9461) (110.449, 0.9785) (115.15, 1.0181) (120.051, 1.0584) (125.16, 1.091) (130.487, 1.1172) (136.04, 1.1406) (141.83, 1.163) (147.866, 1.1848) (154.159, 1.2049) (160.72, 1.2228) (167.56, 1.2394) (174.691, 1.2557) (182.126, 1.2711) (189.878, 1.2848) (197.958, 1.2979) (206.384, 1.3103) (215.167, 1.322) (224.325, 1.3331) (233.872, 1.3437) (243.825, 1.3537) (254.202, 1.3631) (265.021, 1.372) (276.3, 1.3805) (288.059, 1.3882) (300.319, 1.3952) (313.1, 1.4018) (326.425, 1.4088) (340.318, 1.4162) (354.801, 1.4231) (369.902, 1.429) (385.644, 1.4353) (402.057, 1.4417) (419.169, 1.4473) (437.008, 1.4525) (455.607, 1.4574) (474.997, 1.462) (495.213, 1.4677) (516.289, 1.4728) (538.262, 1.4769) (561.17, 1.4812) (585.053, 1.4861) (609.952, 1.4908) (635.912, 1.4948) (662.976, 1.4991) (691.191, 1.5036) (720.608, 1.5081) (751.277, 1.5122) (783.251, 1.516) (816.585, 1.5201) (851.339, 1.5241) (887.571, 1.5269) (925.346, 1.5309) (964.728, 1.5356) (1005.79, 1.5395) (1048.59, 1.5433) (1093.22, 1.5472) (1139.75, 1.5512) (1188.25, 1.5551) (1238.82, 1.5592) (1291.55, 1.5633) (1346.52, 1.5674) (1403.82, 1.5715) (1463.57, 1.5756) (1525.86, 1.5797) (1590.8, 1.5837) (1658.5, 1.5877) (1729.08, 1.5917) (1802.67, 1.5958) (1879.39, 1.5998) (1959.38, 1.6039) (2042.77, 1.6082) (2129.71, 1.6125) (2220.35, 1.617) (2314.84, 1.6216) (2413.36, 1.6261) (2516.07, 1.6307) (2623.16, 1.6352) (2734.8, 1.6397)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}
  ChinaSteel_50CS400_2DSF0.950: permeability{BType=normal HUnit=A_per_meter BUnit=tesla curve (0, 0) (20, 0.0399013) (20.8512, 0.0424663) (21.7386, 0.0452214) (22.6638, 0.0480714) (23.6283, 0.0512065) (24.6339, 0.0544365) (25.6824, 0.0579516) (26.7754, 0.0617517) (27.9149, 0.0659318) (29.103, 0.0704918) (30.3416, 0.0755269) (31.6329, 0.081132) (32.9792, 0.0873071) (34.3827, 0.0943372) (35.846, 0.102127) (37.3716, 0.111057) (38.9621, 0.121127) (40.6204, 0.132718) (42.3491, 0.145828) (44.1515, 0.160743) (46.0305, 0.177748) (47.9896, 0.197033) (50.032, 0.218883) (52.1613, 0.243488) (54.3813, 0.270753) (56.6957, 0.300679) (59.1086, 0.332789) (61.6243, 0.366894) (64.2469, 0.402804) (66.9813, 0.440804) (69.8319, 0.481179) (72.8039, 0.52393) (75.9024, 0.56839) (79.1328, 0.61342) (82.5006, 0.657595) (86.0118, 0.70101) (89.6724, 0.744711) (93.4888, 0.789456) (97.4677, 0.832396) (101.616, 0.868971) (105.941, 0.898802) (110.449, 0.929582) (115.15, 0.967202) (120.051, 1.00549) (125.16, 1.03646) (130.487, 1.06135) (136.04, 1.08358) (141.83, 1.10486) (147.866, 1.12557) (154.159, 1.14466) (160.72, 1.16167) (167.56, 1.17744) (174.691, 1.19293) (182.126, 1.20756) (189.878, 1.22057) (197.958, 1.23302) (206.384, 1.2448) (215.167, 1.25591) (224.325, 1.26646) (233.872, 1.27653) (243.825, 1.28603) (254.202, 1.29496) (265.021, 1.30342) (276.3, 1.31149) (288.059, 1.31881) (300.319, 1.32546) (313.1, 1.33173) (326.425, 1.33838) (340.318, 1.34541) (354.801, 1.35197) (369.902, 1.35757) (385.644, 1.36356) (402.057, 1.36964) (419.169, 1.37496) (437.008, 1.3799) (455.607, 1.38456) (474.997, 1.38893) (495.213, 1.39435) (516.289, 1.39919) (538.262, 1.40309) (561.17, 1.40718) (585.053, 1.41183) (609.952, 1.4163) (635.912, 1.4201) (662.976, 1.42419) (691.191, 1.42846) (720.608, 1.43274) (751.277, 1.43664) (783.251, 1.44025) (816.585, 1.44415) (851.339, 1.44795) (887.571, 1.45061) (925.346, 1.45441) (964.728, 1.45888) (1005.79, 1.46259) (1048.59, 1.4662) (1093.22, 1.46991) (1139.75, 1.47371) (1188.25, 1.47742) (1238.82, 1.48132) (1291.55, 1.48522) (1346.52, 1.48911) (1403.82, 1.49301) (1463.57, 1.49691) (1525.86, 1.50081) (1590.8, 1.50461) (1658.5, 1.50842) (1729.08, 1.51222) (1802.67, 1.51612) (1879.39, 1.51993) (1959.38, 1.52383) (2042.77, 1.52792) (2129.71, 1.53201) (2220.35, 1.53629) (2314.84, 1.54067) (2413.36, 1.54495) (2516.07, 1.54932) (2623.16, 1.5536) (2734.8, 1.55789)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}
  Arnold_Magnetics_N42_20C_2DSF1.000_N: CoordinateSystemType=Cylindrical permeability=1.02121 conductivity=555556 magnetic_coercivity{Magnitude=-991709A_per_meter DirComp1=1 DirComp2=0 DirComp3=0} mass_density=7500
  Arnold_Magnetics_N42_20C_2DSF1.000_S: CoordinateSystemType=Cylindrical permeability=1.02121 conductivity=555556 magnetic_coercivity{Magnitude=-991709A_per_meter DirComp1=-1 DirComp2=0 DirComp3=0} mass_density=7500

design RMxprtDesign1 (RMxprt, Adjust-Speed Synchronous Machine, model units mm)
machine:
  Machine: FrictionLoss=0W WindLoss=0W ReferenceSpeed=5000rpm NumberOfPoles=4 RotorPosition=true ControlType=0 CircuitType=Y3
  Circuit: TriggerPulseWidth=120deg TransistorDrop=0V DiodeDrop=0V ModulationIndex=0 CarrierFrequencyTimes=0
  Stator: SkewWidth=0 NumberOfSlots=48 LaminationSectors=0 PressBoardThickness=0mm OuterDiameter=340mm InnerDiameter=180.8mm Length=80mm StackingFactor=0.95 SteelType=ChinaSteel_50CS400 SlotType=UserDefinedSlot
  Rotor: OuterDiameter=180mm InnerDiameter=20mm Length=80mm SteelType=ChinaSteel_50CS400 PoleType=1 StackingFactor=0.95
  Shaft: MagneticShaft
  Stator Winding: WindingType=Whole-Coiled WindingLayers=1 ParallelBranches=1 ConductorsPerSlot=3 CoilPitch=2 EndAdjustment=0mm BaseInnerRadius=0mm TipInnerDiameter=0mm EndClearance=0mm CoilWrap=0mm SlotLiner=0mm WedgeThickness=0mm LayerInsulation=0mm BottomInsulation=0mm LimitedFillFactor=0.75 WdgNumberofPriodicMultipler=1 NumberOfStrands=1 WireWrap=0mm InterturnInsulation=0mm WireDiameter=0mm WireWidth=0mm WireThickness=0mm Gauge=0
  Rotor Pole: Embrace=0.9 Offset=0mm ShaftDiameter=0mm Bridge=0mm Rib=0mm MagnetThickness=6mm MagnetWidth=0mm MagnetType=Arnold_Magnetics_N42_20C
  Stator UserDefSymmetricSlot: SlotSegmentDef{SegmentType=1 Value1=6.88mm Value2=0 SegmentInfo=0} SlotSegmentDef{SegmentType=2 Value1=1mm Value2=6.88mm SegmentInfo=1} SlotSegmentDef{SegmentType=1 Value1=7.88mm Value2=0mm SegmentInfo=0} SlotSegmentDef{SegmentType=2 Value1=58.6mm Value2=7.88mm SegmentInfo=0} SlotSegmentDef{SegmentType=1 Value1=0mm Value2=0mm SegmentInfo=0}
setups:
  Setup1: ASSM Motor RatedOutputPower=125000W RatedVoltage=520V RatedSpeed=5000rpm OperatingTemperature=75cel LoadType=ConstPower RatedPowerFactor=0.75

design MaxCir1 (Maxwell Circuit)
variables:
  Kle = 1
components:
  Winding_2 = Winding(Name=PhaseA)
  Winding_3 = Winding(Name=PhaseB)
  Winding_4 = Winding(Name=PhaseC)
  Res_5 = Res(Name=A R=0.00333193ohm)
  Res_6 = Res(Name=B R=0.00333193ohm)
  Res_7 = Res(Name=C R=0.00333193ohm)
  Ind_8 = Ind(Name=A L=6.15888e-05H*Kle)
  Ind_9 = Ind(Name=B L=6.15888e-05H*Kle)
  Ind_10 = Ind(Name=C L=6.15888e-05H*Kle)
  Ammeter_11 = Ammeter(Name=IA)
  Ammeter_12 = Ammeter(Name=IB)
  Ammeter_13 = Ammeter(Name=IC)
  VPulse_14 = VPulse(V1=-1 Td=0.00043717 Tr=0 Tf=0 Pw=0.002 Period=0.006)
  VPulse_15 = VPulse(V1=-1 Td=0.00143717 Tr=0 Tf=0 Pw=0.002 Period=0.006)
  VPulse_16 = VPulse(V1=-1 Td=0.00243717 Tr=0 Tf=0 Pw=0.002 Period=0.006)
  VPulse_17 = VPulse(V1=-1 Td=0.00343717 Tr=0 Tf=0 Pw=0.002 Period=0.006)
  VPulse_18 = VPulse(V1=-1 Td=0.00443717 Tr=0 Tf=0 Pw=0.002 Period=0.006)
  VPulse_19 = VPulse(V1=-1 Td=0.00543717 Tr=0 Tf=0 Pw=0.002 Period=0.006)
  Res_20 = Res()
  Res_21 = Res()
  Res_22 = Res()
  Res_23 = Res()
  Res_24 = Res()
  Res_25 = Res()
  VoltmeterG_26 = VoltmeterG(Name=Vc1)
  VoltmeterG_27 = VoltmeterG(Name=Vc2)
  VoltmeterG_28 = VoltmeterG(Name=Vc3)
  VoltmeterG_29 = VoltmeterG(Name=Vc4)
  VoltmeterG_30 = VoltmeterG(Name=Vc5)
  VoltmeterG_31 = VoltmeterG(Name=Vc6)
  VDC_32 = VDC(V=260V)
  VDC_33 = VDC(V=260V)
  DIODE_34 = DIODE(MOD=DModel1)
  DIODE_35 = DIODE(MOD=DModel1)
  DIODE_36 = DIODE(MOD=DModel1)
  DIODE_37 = DIODE(MOD=DModel1)
  DIODE_38 = DIODE(MOD=DModel1)
  DIODE_39 = DIODE(MOD=DModel1)
  DIODE_40 = DIODE(MOD=DModel1)
  DIODE_41 = DIODE(MOD=DModel1)
  DIODE_42 = DIODE(MOD=DModel1)
  DIODE_43 = DIODE(MOD=DModel1)
  DIODE_44 = DIODE(MOD=DModel1)
  DIODE_45 = DIODE(MOD=DModel1)
  SW_V_46 = SW_V(ID_V=IVc1 MOD=SModel1)
  SW_V_47 = SW_V(ID_V=IVc4 MOD=SModel1)
  SW_V_48 = SW_V(ID_V=IVc3 MOD=SModel1)
  SW_V_49 = SW_V(ID_V=IVc6 MOD=SModel1)
  SW_V_50 = SW_V(ID_V=IVc5 MOD=SModel1)
  SW_V_51 = SW_V(ID_V=IVc2 MOD=SModel1)
  DIODE_Model_52 = DIODE_Model(IS=0.002585A DeviceName=DModel1)
  SW_VModel_53 = SW_VModel(Von=0V Voff=0V DeviceName=SModel1)
nets:
  0: VPulse_14.1, VPulse_15.1, VDC_32.1, VDC_33.0, VPulse_17.1, VPulse_19.1, VPulse_18.1, VPulse_16.1
  net_1: Winding_4.1, Winding_3.1, Winding_2.1
  net_10: Ammeter_11.1, Ind_8.0
  net_11: Ammeter_12.1, Ind_9.0
  net_12: Ammeter_13.1, Ind_10.0
  net_19: VPulse_14.0, Res_20.0, VoltmeterG_26.0
  net_20: VPulse_15.0, Res_21.0, VoltmeterG_27.0
  net_21: VPulse_16.0, Res_22.0, VoltmeterG_28.0
  net_22: VPulse_17.0, Res_23.0, VoltmeterG_29.0
  net_23: VPulse_18.0, Res_24.0, VoltmeterG_30.0
  net_24: VPulse_19.0, Res_25.0, VoltmeterG_31.0
  net_25: Res_20.1, Res_22.1, Res_21.1, Res_24.1, Res_25.1, Res_23.1
  net_31: VDC_32.0, DIODE_39.1, DIODE_40.0, DIODE_35.1, DIODE_37.1, DIODE_42.0, DIODE_44.0
  net_33: VDC_33.1, DIODE_34.0, DIODE_36.0, DIODE_38.0, SW_V_47.1, SW_V_51.1, SW_V_49.1
  net_34: DIODE_41.0, DIODE_34.1, DIODE_35.0, SW_V_46.1, Ammeter_11.0
  net_35: DIODE_36.1, DIODE_37.0, DIODE_43.0, SW_V_48.1, Ammeter_12.0
  net_36: Ammeter_13.0, DIODE_39.0, DIODE_38.1, DIODE_45.0, SW_V_50.1
  net_4: Res_5.1, Winding_2.0
  net_40: DIODE_40.1, SW_V_46.0
  net_41: DIODE_41.1, SW_V_47.0
  net_42: DIODE_42.1, SW_V_48.0
  net_43: DIODE_43.1, SW_V_49.0
  net_44: DIODE_44.1, SW_V_50.0
  net_45: DIODE_45.1, SW_V_51.0
  net_5: Winding_3.0, Res_6.1
  net_6: Winding_4.0, Res_7.1
  net_7: Res_5.0, Ind_8.1
  net_8: Ind_9.1, Res_6.0
  net_9: Ind_10.1, Res_7.0

design Maxwell2DDesign1 (Maxwell 2D, Transient, XY geometry, model units mm)
options: ComputeTransientInductance ModelDepth=80mm Multiplier=fractions
variables:
  fractions = 4
geometry:
  Band [vacuum] = user_primitive(RMxprt/Band, DiaGap=180.4mm, DiaYoke=20mm, Length=0mm, SegAngle=0deg, Fractions=1, HalfAxial=0, InfoCore=0)
  Shaft [ChinaSteel_50CS400_2DSF0.950] = user_primitive(RMxprt/Band, DiaGap=180.4mm, DiaYoke=20mm, Length=0mm, SegAngle=0deg, Fractions=1, HalfAxial=0, InfoCore=100)
  OuterRegion [vacuum] = user_primitive(RMxprt/Band, DiaGap=180.4mm, DiaYoke=340mm, Length=0mm, SegAngle=0deg, Fractions=fractions, HalfAxial=0, InfoCore=100)
  Tool = user_primitive(RMxprt/Band, DiaGap=180.4mm, DiaYoke=340mm, Length=0mm, SegAngle=0deg, Fractions=fractions, HalfAxial=0, InfoCore=1)
  Stator [ChinaSteel_50CS400_2DSF0.950] = user_primitive(RMxprt/SlotCore, DiaGap=180.8mm, DiaYoke=340mm, Length=0mm, Skew=0deg, Slots=48, SlotType=0, Hs0=1mm, Hs01=0mm, Hs1=0mm, Hs2=58.6mm, Bs0=6.88mm, Bs1=7.8799889mm, Bs2=7.8799889mm, Rs=0mm, FilletType=0, HalfSlot=0, SegAngle=15deg, LenRegion=0mm, InfoCore=0)
  StatorSlot = polyline(z=0mm, xy in mm: (3.44, -91.334525) (3.94, -91.334525) (3.94, -149.93452) (0, -149.93452) (0, -89.496) (3.44, -89.496) (3.44, -91.334525), closed, covered)
  StatorSlot1 = polyline(z=0mm, xy in mm: (3.44, -91.334525) (3.94, -91.334525) (3.94, -149.93452) (0, -149.93452) (0, -89.496) (3.44, -89.496) (3.44, -91.334525), closed, covered)
  StatorSlot1.mirror(point=(0mm, 0mm, 0mm), normal=(1mm, 0mm, 0mm))
  StatorSlot.unite(StatorSlot1)
  StatorSlot.rotate(axis=Z, angle=90deg)
  StatorSlot.rotate(axis=Z, angle=3.75deg)
  StatorSlot_1..StatorSlot_47 = StatorSlot.duplicate_around_axis(axis=Z, angle=7.5deg, total=48)
  StatorSlot.unite(StatorSlot_1..StatorSlot_47)
  Stator.subtract(StatorSlot)
  Coil_0 [copper] = user_primitive(RMxprt/LapCoil, DiaGap=180.8mm, DiaYoke=340mm, Length=0mm, Skew=0deg, Slots=48, SlotType=0, Hs0=1mm, Hs1=0mm, Hs2=58.6mm, Bs0=6.88mm, Bs1=7.8799889mm, Bs2=7.8799889mm, Rs=0mm, FilletType=0, Layers=1, CoilPitch=2, EndExt=0mm, SpanExt=0mm, BendAngle=0deg, SegAngle=10deg, LenRegion=0mm, InfoCoil=2)
  Coil_1..Coil_11 [copper], Coil_12..Coil_47 = Coil_0.duplicate_around_axis(axis=Z, angle=7.5deg, total=48)
  Coil_0.unite(Coil_12, Coil_24, Coil_36)
  Coil_1.unite(Coil_13, Coil_25, Coil_37)
  Coil_2.unite(Coil_14, Coil_26, Coil_38)
  Coil_3.unite(Coil_15, Coil_27, Coil_39)
  Coil_4.unite(Coil_16, Coil_28, Coil_40)
  Coil_5.unite(Coil_17, Coil_29, Coil_41)
  Coil_6.unite(Coil_18, Coil_30, Coil_42)
  Coil_7.unite(Coil_19, Coil_31, Coil_43)
  Coil_8.unite(Coil_20, Coil_32, Coil_44)
  Coil_9.unite(Coil_21, Coil_33, Coil_45)
  Coil_10.unite(Coil_22, Coil_34, Coil_46)
  Coil_11.unite(Coil_23, Coil_35, Coil_47)
  Rotor [ChinaSteel_50CS400_2DSF0.950] = user_primitive(RMxprt/PMCore, DiaGap=180mm, DiaYoke=20mm, Length=0mm, Poles=4, PoleType=1, Embrace=0.9, ThickMag=6mm, WidthMag=0mm, Offset=0mm, Bridge=0mm, Rib=0mm, LenRegion=0mm, InfoCore=0)
  Mag_0 [Arnold_Magnetics_N42_20C_2DSF1.000_N] = user_primitive(RMxprt/PMCore, DiaGap=180mm, DiaYoke=20mm, Length=0mm, Poles=4, PoleType=1, Embrace=0.9, ThickMag=6mm, WidthMag=0mm, Offset=0mm, Bridge=0mm, Rib=0mm, LenRegion=0mm, InfoCore=2)
  Mag_1, Mag_2, Mag_3 = Mag_0.duplicate_around_axis(axis=Z, angle=90deg, total=4)
  Mag_0.unite(Mag_1, Mag_2, Mag_3)
  InnerRegion [vacuum] = user_primitive(RMxprt/PMCore, DiaGap=180mm, DiaYoke=20mm, Length=0mm, Poles=4, PoleType=1, Embrace=0.9, ThickMag=6mm, WidthMag=0mm, Offset=0mm, Bridge=0mm, Rib=0mm, LenRegion=0mm, InfoCore=100)
  Tool_1 = Tool.copy()
  Band.subtract(Tool_1)
  Tool_2 = Tool.copy()
  InnerRegion.subtract(Tool_2)
  Tool_3 = Tool.copy()
  Shaft.subtract(Tool_3)
  Tool_4 = Tool.copy()
  Stator.subtract(Tool_4)
  Tool_5 = Tool.copy()
  Coil_0.subtract(Tool_5)
  Tool_6 = Tool.copy()
  Coil_1.subtract(Tool_6)
  Tool_7 = Tool.copy()
  Coil_2.subtract(Tool_7)
  Tool_8 = Tool.copy()
  Coil_3.subtract(Tool_8)
  Tool_9 = Tool.copy()
  Coil_4.subtract(Tool_9)
  Tool_10 = Tool.copy()
  Coil_5.subtract(Tool_10)
  Tool_11 = Tool.copy()
  Coil_6.subtract(Tool_11)
  Tool_12 = Tool.copy()
  Coil_7.subtract(Tool_12)
  Tool_13 = Tool.copy()
  Coil_8.subtract(Tool_13)
  Tool_14 = Tool.copy()
  Coil_9.subtract(Tool_14)
  Tool_15 = Tool.copy()
  Coil_10.subtract(Tool_15)
  Tool_16 = Tool.copy()
  Coil_11.subtract(Tool_16)
  Tool_17 = Tool.copy()
  Rotor.subtract(Tool_17)
  Mag_0.subtract(Tool)
motion:
  MotionSetup1: Band Move_Type=Rotate Coordinate_System=Global Axis=Z Is_Positive=true InitPos=15deg Angular_Velocity=5000rpm Objects=Band
  Moving1: Moving Objects=[Shaft, Rotor, Mag_0, InnerRegion]
boundaries and excitations:
  VectorPotential1: Vector Potential Edges=OuterRegion.edge(at (120.208, 120.208, 0)) Value=0
  Master1: Master Edges=OuterRegion.edge(at (85, 0, 0))
  Slave1: Slave Edges=OuterRegion.edge(at (0, 85, 0)) ReverseU master=Master1 SameAsMaster=false
  PhA_0: Coil Objects=Coil_0 Conductor_number=3 Winding=PhaseA PolarityType=Positive
  PhA_1: Coil Objects=Coil_1 Conductor_number=3 Winding=PhaseA PolarityType=Positive
  PhA_2: Coil Objects=Coil_2 Conductor_number=3 Winding=PhaseA PolarityType=Positive
  PhA_3: Coil Objects=Coil_3 Conductor_number=3 Winding=PhaseA PolarityType=Positive
  PhB_4: Coil Objects=Coil_8 Conductor_number=3 Winding=PhaseB PolarityType=Positive
  PhB_5: Coil Objects=Coil_9 Conductor_number=3 Winding=PhaseB PolarityType=Positive
  PhB_6: Coil Objects=Coil_10 Conductor_number=3 Winding=PhaseB PolarityType=Positive
  PhB_7: Coil Objects=Coil_11 Conductor_number=3 Winding=PhaseB PolarityType=Positive
  PhCRe_8: Coil Objects=Coil_6 Conductor_number=3 Winding=PhaseC PolarityType=Negative
  PhCRe_9: Coil Objects=Coil_7 Conductor_number=3 Winding=PhaseC PolarityType=Negative
  PhCRe_22: Coil Objects=Coil_4 Conductor_number=3 Winding=PhaseC PolarityType=Negative
  PhCRe_23: Coil Objects=Coil_5 Conductor_number=3 Winding=PhaseC PolarityType=Negative
  PhaseA: Winding Group Type=External IsSolid=false Current=0A ParallelBranchesNum=1
  PhaseB: Winding Group Type=External IsSolid=false Current=0A ParallelBranchesNum=1
  PhaseC: Winding Group Type=External IsSolid=false Current=0A ParallelBranchesNum=1
  external circuit: "* Design: MaxCir1\"
mesh:
  SurfApprox_Mag: SurfApproxBased Objects=Mag_0 CurvedSurfaceApproxChoice=ManualSettings SurfDev=0.09mm NormalDev=15deg
  SurfApprox_Main: SurfApproxBased Objects=[Stator, Rotor, Band, OuterRegion, InnerRegion, Shaft] CurvedSurfaceApproxChoice=ManualSettings SurfDev=0.17mm NormalDev=15deg
  initial mesh: MeshMethod=AnsoftTAU
setups:
  Setup1: Transient NonlinearSolverResidual=0.0001 StopTime=0.012s TimeStep=6e-05s InitialTimeStep=0.002s MinTimeStep=0.001s MaxTimeStep=0.003s TimeStepErrTolerance=0.0001
output variables:
  pos = (Moving1.Position -15 * PI/180) * 2 + PI
  cos0 = cos(pos)
  cos1 = cos(pos-2*PI/3)
  cos2 = cos(pos-4*PI/3)
  sin0 = sin(pos)
  sin1 = sin(pos-2*PI/3)
  sin2 = sin(pos-4*PI/3)
  Lad = L(PhaseA,PhaseA)*cos0 + L(PhaseA,PhaseB)*cos1 + L(PhaseA,PhaseC)*cos2
  Laq = L(PhaseA,PhaseA)*sin0 + L(PhaseA,PhaseB)*sin1 + L(PhaseA,PhaseC)*sin2
  Lbd = L(PhaseB,PhaseA)*cos0 + L(PhaseB,PhaseB)*cos1 + L(PhaseB,PhaseC)*cos2
  Lbq = L(PhaseB,PhaseA)*sin0 + L(PhaseB,PhaseB)*sin1 + L(PhaseB,PhaseC)*sin2
  Lcd = L(PhaseC,PhaseA)*cos0 + L(PhaseC,PhaseB)*cos1 + L(PhaseC,PhaseC)*cos2
  Lcq = L(PhaseC,PhaseA)*sin0 + L(PhaseC,PhaseB)*sin1 + L(PhaseC,PhaseC)*sin2
  L_d = (Lad*cos0 + Lbd*cos1 + Lcd*cos2) * 2/3
  L_q = (Laq*sin0 + Lbq*sin1 + Lcq*sin2) * 2/3
  Flux_d = FluxLinkage(PhaseA)*cos0 + FluxLinkage(PhaseB)*cos1 + FluxLinkage(PhaseC)*cos2
  Flux_q = FluxLinkage(PhaseA)*sin0 + FluxLinkage(PhaseB)*sin1 + FluxLinkage(PhaseC)*sin2
  I_d = Current(PhaseA)*cos0 + Current(PhaseB)*cos1 + Current(PhaseC)*cos2
  I_q = Current(PhaseA)*sin0 + Current(PhaseB)*sin1 + Current(PhaseC)*sin2
  Irms = sqrt(I_d^2+I_q^2)*2/3/sqrt(2)
  Pcu = 3*Irms^2*0
reports:
  Torque: Moving1.Torque vs Time on Setup1 : Transient
  Currents: Current(PhaseA), Current(PhaseB), Current(PhaseC) vs Time on Setup1 : Transient
  Induced Voltages: InducedVoltage(PhaseA), InducedVoltage(PhaseB), InducedVoltage(PhaseC) vs Time on Setup1 : Transient
  Flux Linkages: FluxLinkage(PhaseA), FluxLinkage(PhaseB), FluxLinkage(PhaseC) vs Time on Setup1 : Transient
  L_dq: L_d, L_q vs Time on Setup1 : Transient
  Flux_dq: Flux_d, Flux_q vs Time on Setup1 : Transient
  I_dq: I_d, I_q vs Time on Setup1 : Transient
